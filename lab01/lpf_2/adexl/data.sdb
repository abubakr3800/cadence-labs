ADE simulation setup
Run mode: Single Run, Sweeps and Corners
Tests:
  lab01:lpf_2:1: lab01/lpf_2/schematic, simulator spectre
  lab01:lpf_2:2 (off): lab01/lpf_2/schematic, simulator spectre
Global variables:
  CL = .2p
  RL = {From/To}Auto:1k:4:1000k{From/To}
  VDD = 1
  TCLK = 20n

ADE simulation setup
Run mode: Single Run, Sweeps and Corners
Tests:
  lab02_feedback:feedback:1: lab02_feedback/feedback/schematic, simulator spectre
Global variables:
  VSIG = 0

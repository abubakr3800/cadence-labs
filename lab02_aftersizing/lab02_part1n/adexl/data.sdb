ADE simulation setup
Run mode: Single Run, Sweeps and Corners
Tests:
  lab02_aftersizing:lab02_part1n:1: lab02_aftersizing/lab02_part1n/schematic, simulator spectre
Global variables:
  L = 2u
  W = 10u * 100/ 49.87
  VGS = 1.8/2

ADE simulation setup
Run mode: Single Run, Sweeps and Corners
Tests:
  lab1_moslib:moslib:1: lab1_moslib/moslib/schematic, simulator spectre
    Outputs: nil
Global variables:
  L = 2u
  VDS = 1.8
  VGS = 0:.2:1.8
  W = 40u

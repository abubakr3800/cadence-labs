ADE simulation setup
Run mode: Single Run, Sweeps and Corners
Tests:
  lab03_part1:part1:1: lab03_part1/part1/schematic, simulator spectre
Global variables:
  L = .5u
  VGS = 0
  W = 20u
  VDS = 1.8
  CL = 1p
  IB = 20u
  VB = 680m + 50m
  VDD = 1.8

ADE simulation setup
Run mode: Single Run, Sweeps and Corners
Tests:
  lab02_sizechart:lab02_part1:1: lab02_sizechart/lab02_part1/schematic, simulator spectre
Global variables:
  L = 2u
  VDS = 1.8/2
  VGS = 0
  W = 5*L

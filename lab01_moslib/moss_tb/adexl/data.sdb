ADE simulation setup
Run mode: Single Run, Sweeps and Corners
Tests:
  lab01_moslib:moss_tb:1: lab01_moslib/moss_tb/schematic, simulator spectre
Global variables:
  L = 40u
  W = 2u
  VDS = 1.8
  VGS = 0
  VDD = 1.8 (off)
